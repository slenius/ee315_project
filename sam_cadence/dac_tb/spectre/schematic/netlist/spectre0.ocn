simulator( 'spectre )
design(	 "/home/sam/ee315_project/sam_cadence/simulation/dac_tb/spectre/schematic/netlist/netlist")
resultsDir( "/home/sam/ee315_project/sam_cadence/simulation/dac_tb/spectre/schematic" )
modelFile(
    '("/afs/ir.stanford.edu/class/ee315/models/ee315_90nm.mod" "")
)
analysis('tran ?stop "60n"  )
desVar(	  "tsample" "tbit*1.5"	)
desVar(	  "tper" "1/fs"	)
desVar(	  "tbit" "(1/fs)/12"	)
desVar(	  "fin" "3/64*fs"	)
desVar(	  "vh" "vdd"	)
desVar(	  "pn_b" 2	)
desVar(	  "pn_a" 2	)
desVar(	  "wu" 1u	)
desVar(	  "vref" 0.6	)
desVar(	  "vl" 0	)
desVar(	  "vdd" 1.2	)
desVar(	  "vcm" 600m	)
desVar(	  "fs" 50M	)
desVar(	  "dc_in" 0	)
desVar(	  "amp" 0	)
envOption(
	'analysisOrder  list("tran")
)
temp( 27 )
run()
selectResult( 'tran )
plot(getData("/dacout_2_m") getData("/dacout_2_p") )
modelFile(
    '("/afs/ir.stanford.edu/class/ee315/models/ee315_90nm.mod" "")
)
run()
selectResult( 'tran )
plot(getData("/nb_2_p<2>") getData("/nb_2_p<1>") getData("/nb_2_p<0>") getData("/na_2_p<2>") getData("/na_2_p<1>") getData("/na_2_p<0>") getData("/dacout_m") getData("/dacout_p") getData("/dacout_2_m") getData("/dacout_2_p") )
modelFile(
    '("/afs/ir.stanford.edu/class/ee315/models/ee315_90nm.mod" "")
)
run()
selectResult( 'tran )
plot(getData("/nb_2_p<2>") getData("/nb_2_p<1>") getData("/nb_2_p<0>") getData("/na_2_p<2>") getData("/na_2_p<1>") getData("/na_2_p<0>") getData("/dacout_m") getData("/dacout_p") getData("/dacout_2_m") getData("/dacout_2_p") )
modelFile(
    '("/afs/ir.stanford.edu/class/ee315/models/ee315_90nm.mod" "")
)
desVar(	  "wu_bot_p" "wu_sample"	)
desVar(	  "wu_top_n" "wu_sample"	)
desVar(	  "wu_sample" 1u	)
run()
selectResult( 'tran )
plot(getData("/nb_2_p<2>") getData("/nb_2_p<1>") getData("/nb_2_p<0>") getData("/na_2_p<2>") getData("/na_2_p<1>") getData("/na_2_p<0>") getData("/dacout_m") getData("/dacout_p") getData("/dacout_2_m") getData("/dacout_2_p") )
modelFile(
    '("/afs/ir.stanford.edu/class/ee315/models/ee315_90nm.mod" "")
)
run()
selectResult( 'tran )
plot(getData("/nb_2_p<2>") getData("/nb_2_p<1>") getData("/nb_2_p<0>") getData("/na_2_p<2>") getData("/na_2_p<1>") getData("/na_2_p<0>") getData("/dacout_m") getData("/dacout_p") getData("/dacout_2_m") getData("/dacout_2_p") )
modelFile(
    '("/afs/ir.stanford.edu/class/ee315/models/ee315_90nm.mod" "")
)
desVar(	  "wu_sample" 180n	)
run()
selectResult( 'tran )
plot(getData("/nb_2_p<2>") getData("/nb_2_p<1>") getData("/nb_2_p<0>") getData("/na_2_p<2>") getData("/na_2_p<1>") getData("/na_2_p<0>") getData("/dacout_m") getData("/dacout_p") getData("/dacout_2_m") getData("/dacout_2_p") )
modelFile(
    '("/afs/ir.stanford.edu/class/ee315/models/ee315_90nm.mod" "")
)
run()
selectResult( 'tran )
plot(getData("/nb_2_p<1>") getData("/na_2_p<1>") getData("/nb_2_m<1>") getData("/na_2_m<1>") getData("/dacout_m") getData("/dacout_p") getData("/dacout_2_m") getData("/dacout_2_p") )
modelFile(
    '("/afs/ir.stanford.edu/class/ee315/models/ee315_90nm.mod" "")
)
run()
selectResult( 'tran )
plot(getData("/dacout_m") getData("/dacout_p") getData("/dacout_2_m") getData("/dacout_2_p") getData("/na_2_m<1>") getData("/nb_2_m<1>") getData("/na_2_p<1>") getData("/nb_2_p<1>") )
modelFile(
    '("/afs/ir.stanford.edu/class/ee315/models/ee315_90nm.mod" "")
)
analysis('tran ?stop "45n"  )
run()
selectResult( 'tran )
plot(getData("/dacout_m") getData("/dacout_p") getData("/dacout_2_m") getData("/dacout_2_p") getData("/na_2_m<1>") getData("/nb_2_m<1>") getData("/na_2_p<1>") getData("/nb_2_p<1>") )
plot( VAR("wu_bot_p") )
plot( VAR("wu_top_n") )
