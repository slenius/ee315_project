// VerilogA for Project_Lib2, bin2v_10bit, veriloga

`include "constants.vams"
`include "disciplines.vams"

module bin2v_10bit(Din, Vout);
input [0:9] Din;
electrical [0:9] Din;
output Vout;
electrical Vout;

parameter vth = 0.6;
real code;
genvar i;

analog begin

  code = 0;
  for (i=0; i<10; i=i+1) begin
    if (V(Din[i]) > vth) begin
      code = code + pow(2,i);
    end
  end

  V(Vout) <+ (code - 511) / 1024;

end
endmodule
