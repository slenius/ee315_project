// VerilogA for Noam, cmp_ideal, veriloga

`include "constants.vams"
`include "disciplines.vams"

module cmp_ideal(vip,vim,vrefp,vrefm,clk,outp,outm);
input vip,vim,vrefp,vrefm,clk;
output outp,outm;
electrical vip,vim,vrefp,vrefm,clk,outp,outm;

parameter real vh=1.2;
parameter real vl=0;
parameter real gain=1000;
parameter real td = 50p from [0:inf);
parameter real tt = 50p from [0:inf);

real outp1,outm1,outd1,vrefd1;

analog begin
	@(cross(V(clk)-0.5*vh,+1)) begin
		outd1=V(vip)-V(vim);
		vrefd1=V(vrefp)-V(vrefm);
		if (outd1 >= vrefd1) begin
			outp1=vh;
			outm1=vl;
			end
		else begin
			outp1=vl;
			outm1=vh;
			end
		end
	V(outp) <+ transition(outp1,td,tt);
	V(outm) <+ transition(outm1,td,tt);
	end
endmodule
